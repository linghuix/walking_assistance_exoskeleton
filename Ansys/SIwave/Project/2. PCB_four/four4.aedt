# Ansys Electronics Desktop project, version 2018.2
materials:
  air: permittivity=1.0006 permeability=1.0000004
  copper: permittivity=1 permeability=0.999991 conductivity=58000000
  FR4_epoxy: permittivity=4.4 permeability=1 dielectric_loss_tangent=0.02
  pec: conductivity=1e+30
  vacuum: permittivity=1

design PCB (HFSS 3D Layout)
ports:
  Port4, Port5, Port7: Properties{Impedance=50ohm Magnitude=1V Phase=0deg Renormalize_Impedence="50ohm + 0i ohm" Renormalize Deembed_Distance=0mil Deembed Type=Circuit HFSS_Type=Circuit Orientation=Horizontal Layer_Alignment=Lower Horizontal_Extent_Factor=5 Vertical_Extent_Factor=3 PEC_Launch_Width=0mil Reference_Net=GND} Type=EdgePort CircuitPort
setups:
  HFSS Setup 1: SolveSetupType=HFSS PercentRefinementPerPass=30 MinNumberOfPasses=1 MinNumberOfConvergedPasses=1 Frequency=10GHz MeshSizeFactor=1.5 ViaNumSides=6 ViaMaterial=copper Style25DVia=Mesh
    sweep Sweep 1: LIN 0GHz 20GHz 0.05GHz; FastSweep SAbsError=0.005 ZoPercentError=1 PassivityTolerance=0.0001 MaxSolutions=250 InterpUseSMatrix InterpUsePortImpedance InterpUseFullBasis MagMinThreshold=0.01
